ADE simulation setup
Run mode: Single Run, Sweeps and Corners
Tests:
  mini_biquad:mini_biquad_circuit:1: mini_biquad/mini_biquad_circuit/schematic, simulator spectre
Global variables:
  vdd_n = -vdd_p
  Vdd_p = 12
  C = 1
  H = 1
  Q = 1.7
  R = 1
  VIN = 1
