ADE simulation setup
Run mode: Single Run, Sweeps and Corners
Tests:
  mini_biquad:mini_biquad_circuit:1: mini_biquad/mini_biquad_circuit/schematic, simulator spectre
    Outputs: Band Pass phase; Band Stop trans; High Pass trans; Low Pass trans; Band Pass trans
Global variables:
  vdd_n = -1
  Vdd_p = 1
  C = 10p
  H = 1
  Q = 1.7
  R = 3.183k
  VIN = 1
  f_trans = 1
