ADE simulation setup
Run mode: Single Run, Sweeps and Corners
Tests:
  folded_cascode:Folded_cascode_full_circuit:1 (off): folded_cascode/Folded_cascode_full_circuit/schematic, simulator spectre
    Outputs: V_out_dB; GBW
  folded_cascode:Closed_Loop_TB:1 (off): folded_cascode/Closed_Loop_TB/schematic, simulator spectre
  folded_cascode:Folded_cascode_unity_feedback:1: folded_cascode/Folded_cascode_unity_feedback/schematic, simulator spectre
Global variables:
  L_cascN = 500n
  L_cascp = 400n
  L_CM = 500n
  L_fold = 400n
  L_in = 500n
  VDD_AC = 0
  VDIFF_AC = 1
  VDIFF_DC = 0
  VINCM_AC = 0
  VINCM_DC = 1.65
  W_cascN = 10.15u
  W_cascp = 10u
  W_CM = 1.25u
  W_fold = 28.36u
  W_in = 60u
  ISS = 130u
  Vb1 = 2.54
  Vb2 = 1.94
  Vb3 = 1.35
  VIN_DC = 1.65
  Vb0 = 650m
  W_CS = 110u
  L_CS = 1u
  LB_CM1 = 400n
  WB_CM1 = 5.9u
  LB_VB0 = 1u
  WB_VB0 = 28.7u
  LB_VB2_CASC = 400n
  LB_VB2_CM = 1u
  WB_CM2 = WB_VB0/2
  WB_VB2_CASC = 4.2u
  WB_VB2_CM = 1.21u
  LB_CM3 = 400n
  LB_VB3_CASC = 500n
  LB_VB3_CM = 1u
  WB_CM3 = WB_VB0/2/2
  WB_VB3_CASC = 27.61u/2
  WB_VB3_CM = 740n
