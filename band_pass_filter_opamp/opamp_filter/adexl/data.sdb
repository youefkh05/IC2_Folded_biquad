ADE simulation setup
Run mode: Single Run, Sweeps and Corners
Tests:
  band_pass_filter_opamp:opamp_filter:1: band_pass_filter_opamp/opamp_filter/schematic, simulator spectre
Corners:
  Resistor by Half (off): C32=2*0.557375143p; C33=2*2.12272554p; C52=2*0.850591634p; C53=2*0.486455956p; R12=17111.1206133/2; R13=29919.6173029/2; C3=2*1.08772903p; C5=2*0.397456426p; R1=36619.2998633/2
  C15Up (off): C32=1.15*0.557375143p; C33=1.15*2.12272554p; C52=1.15*0.850591634p; C53=1.15*0.486455956p; R12=17111.1206133; R13=29919.6173029; C3=1.15*1.08772903p; C5=1.15*0.397456426p; R1=36619.2998633
  C15down (off): C32=0.85*0.557375143p; C33=0.85*2.12272554p; C52=0.85*0.850591634p; C53=0.85*0.486455956p; R12=17111.1206133; R13=29919.6173029; C3=0.85*1.08772903p; C5=0.85*0.397456426p; R1=36619.2998633
  C2up (off): C32=0.557375143p; C33=2.12272554p; C52=0.850591634p; C53=0.486455956p; R12=17111.1206133; R13=29919.6173029; C3=1.02*1.08772903p; C5=1.02*0.397456426p; R1=36619.2998633
  C2udown (off): C32=0.557375143p; C33=2.12272554p; C52=0.850591634p; C53=0.486455956p; R12=17111.1206133; R13=29919.6173029; C3=0.98*1.08772903p; C5=0.98*0.397456426p; R1=36619.2998633
  Gain 100 (off): OP_GAIN=100
  BW20M: C_BW=1p; R_BW=7957.74
  BW2M: C_BW=1p; R_BW=79577.47
