ADE simulation setup
Run mode: Single Run, Sweeps and Corners
Tests:
  band_pass_filter_opamp:opamp_filter:1: band_pass_filter_opamp/opamp_filter/schematic, simulator spectre
